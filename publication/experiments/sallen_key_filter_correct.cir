* Sallen-Key Low-Pass Filter - CORRECT VERSION
* Фильтр нижних частот Саллена-Ки - правильная версия
*
* Параметры фильтра:
* Частота среза: ~1 кГц (расчетная)
* Коэффициент усиления: K = 1 + R4/R3 = 3.2
*
* Эта версия исправлена: узел VFB правильно подключен к +IN ОУ

* Входной сигнал
VIN VIN 0 AC 1

* Пассивная RC-цепь фильтра
R1 VIN N1 10k
C1 N1 N2 10n
R2 N2 N3 10k
C2 N3 0 10n

* Положительная обратная связь (делитель напряжения)
* R3 подключен от узла N3 к узлу VFB
R3 N3 VFB 10k
* R4 подключен от выхода к узлу VFB
R4 VOUT VFB 22k

* ПРАВИЛЬНО: Узел VFB подключен к положительному входу ОУ
* Операционный усилитель
XOPAMP VFB 0 VOUT VCC VEE VOUT OPAMP

* Питание операционного усилителя
VCC VCC 0 15
VEE VEE 0 -15

* Модель операционного усилителя (идеальный, с высоким усилением)
.subckt OPAMP +IN -IN OUT VCC VEE
E1 OUT 0 +IN -IN 1000000
.ends OPAMP

* Анализ частотной характеристики
.ac dec 100 10 100k
.end
